.title KiCad schematic
V1 Net-_R1-Pad1_ 0 DC 0 AC 1 PULSE(0 1 0 1u 1u 1 2)
R1 Net-_R1-Pad1_ Net-_C1-Pad1_ 1k
C1 Net-_C1-Pad1_ 0 100n
.end
